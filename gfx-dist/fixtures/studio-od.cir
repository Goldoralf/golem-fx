* Studio OD
* generated by gfx-dsp circuit_nl::Netlist::to_spice
.temp 25
VIN0 n1 0 DC 0
VIN1 n2 0 DC 8.65
VIN2 n3 0 DC 4.325
R0 n1 n4 3.3e4
R1 n4 0 1e6
E2 n5 0 n4 0 1
C3 n5 n6 6.8e-8
R4 n6 n7 2.7e3
C5 n7 0 2.2e-8
R6 n7 n3 1e4
B7in 0 n10 I = 5.1e-5 * tanh(V(n7,n8)/9.018780108540736e-2)
B7rail n10 0 I = 5.6548667764616275e-9 * (V(n10) - 4.325) + 5.099999999999999e-5 * ln(1 + exp((V(n10) - 7.65) / 0.05)) - 5.099999999999999e-5 * ln(1 + exp((1 - V(n10)) / 0.05))
C8 n10 0 3e-11
E9 n9 0 n10 0 1
R10 n8 n11 1.5e3
C11 n11 0 2.2e-6
R12 n8 n12 8.2e2
C13 n12 0 8.2e-8
C14 n8 n9 1.2e-10
D15_0_0 n8 n9 D150J
D15_1_0 n9 n8 D151J
R16 n8 n13 1.8e3
R17 n13 n9 2.2727272727272728e4
C18 n9 n14 2.2e-6
R19 n14 n15 1.2e4
C20 n15 0 2.7e-9
D21_0_0 n15 n3 D210J
D21_1_0 n3 n15 D211J
R22 n15 n16 3.9e4
C23 n16 n17 8.2e-8
C24 n17 0 1e-9
R25 n17 0 1.2e4
R26 n16 n18 1e4
R27 n18 n3 4.3e4
C28 n18 n19 2.2e-8
R29 n18 n19 5.1e3
R30 n19 n20 1.25e4
R31 n20 n21 1.25e4
R32 n21 n22 1.2e3
C33 n20 0 2.7e-8
C34 n20 n23 1e-7
C35 n23 n24 8.2e-9
R36 n24 n3 1.5e5
E37 n26 0 n24 0 1
R38 n26 n25 2.569257912108585e1
R39 n24 n25 1.027703164843434e4
R40 n25 0 3.3e3
R41 n23 n25 2.2e3
E42 n27 0 n18 n22 1e9
R43 n22 n3 1e4
R44 n27 n22 2e4
C45 n27 n22 5.6e-10
R46 n27 n28 4.7e3
C47 n28 0 8.2e-9
B48in 0 n31 I = 5.1e-5 * tanh(V(n28,n29)/9.018780108540736e-2)
B48rail n31 0 I = 5.6548667764616275e-9 * (V(n31) - 4.325) + 5.099999999999999e-5 * ln(1 + exp((V(n31) - 7.65) / 0.05)) - 5.099999999999999e-5 * ln(1 + exp((1 - V(n31)) / 0.05))
C49 n31 0 3e-11
E50 n30 0 n31 0 1
R51 n29 n32 1.2e3
C52 n32 0 1e-6
R53 n30 n29 2.2e4
C54 n30 n29 4.7e-9
C55 n30 n33 8.2e-8
R56 n33 n29 5.1e3
C57 n30 n34 2.2e-6
R58 n34 n3 5e4
C59 n34 n35 4.7e-7
R60 n35 n3 1.5e5
E61 n36 0 n35 0 1
C62 n36 n37 1e-6
R63 n37 0 1.5e5
.model D150J D(IS=2.52e-9 N=1.752 EG=1.11 XTI=3 TNOM=25)
.model D151J D(IS=2.52e-9 N=1.752 EG=1.11 XTI=3 TNOM=25)
.model D210J D(IS=2.52e-9 N=1.752 EG=1.11 XTI=3 TNOM=25)
.model D211J D(IS=2.52e-9 N=1.752 EG=1.11 XTI=3 TNOM=25)
.op
.print op V(n37)
.end
