* Blend OD
* generated by gfx-dsp circuit_nl::Netlist::to_spice
.temp 25
VIN0 n1 0 DC 0
VIN1 n2 0 DC 9
VIN2 n3 0 DC 4.5
C0 n1 n4 1e-7
R1 n4 n3 1e6
E2 n5 0 n4 0 1
C3 n5 n6 1e-7
R4 n6 n7 1e4
R5 n7 n3 1e6
B6in 0 n10 I = 3.9e-4 * tanh(V(n7,n8)/6.896714200648798e-1)
B6rail n10 0 I = 2.8274333882308137e-9 * (V(n10) - 4.5) + 3.9e-4 * ln(1 + exp((V(n10) - 7.5) / 0.05)) - 3.9e-4 * ln(1 + exp((1.5 - V(n10)) / 0.05))
C7 n10 0 3e-11
E8 n9 0 n10 0 1
R9 n9 n8 4.22e5
C10 n9 n8 3.9e-10
R11 n8 n11 1.5e4
C12 n8 n11 8.2e-8
R13 n11 n12 2e3
R14 n12 n3 5e4
C15 n9 n13 1e-6
R16 n13 n14 1e3
D17_0_0 n14 0 D170J
D17_1_0 0 n14 D171J
C18 n14 n15 1e-6
R19 n15 n16 4.7e4
R20 n5 n17 5e4
R21 n17 n3 5e4
R22 n17 n16 2.7e4
R23 n17 n18 1.2e4
C24 n18 n16 2.7e-8
R25 n17 n19 2.2e4
C26 n19 n15 2.2e-9
R27 n5 n20 1.5e3
C28 n20 n3 1e-6
R29 n20 n16 1.5e4
B30in 0 n22 I = 3.9e-4 * tanh(V(n3,n16)/6.896714200648798e-1)
B30rail n22 0 I = 2.8274333882308137e-9 * (V(n22) - 4.5) + 3.9e-4 * ln(1 + exp((V(n22) - 16.5) / 0.05)) - 3.9e-4 * ln(1 + exp((-7.5 - V(n22)) / 0.05))
C31 n22 0 3e-11
E32 n21 0 n22 0 1
R33 n21 n16 3.92e5
C34 n21 n16 8.2e-10
R35 n21 n23 1e4
R36 n24 n23 1e4
E37 n24 0 n3 n23 1e9
R38 n24 n25 5e3
R39 n25 n21 5e3
C40 n25 n23 3.9e-9
C41 n24 n26 4.7e-6
R42 n26 0 1e4
.model D170J D(IS=2e-7 N=1.3 EG=0.67 XTI=3 TNOM=25)
.model D171J D(IS=2e-7 N=1.3 EG=0.67 XTI=3 TNOM=25)
.op
.print op V(n26)
.end
