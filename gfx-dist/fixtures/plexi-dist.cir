* Plexi Dist
* generated by gfx-dsp circuit_nl::Netlist::to_spice
.temp 25
VIN0 n1 0 DC 0
VIN1 n2 0 DC 8.7
VIN2 n3 0 DC 4.35
C0 n1 n4 1e-8
R1 n4 n3 1e6
B2in 0 n7 I = 2.1e-4 * tanh(V(n4,n5)/7.427230677621782e-2)
B2rail n7 0 I = 2.827433388230814e-8 * (V(n7) - 4.35) + 2.1e-4 * ln(1 + exp((V(n7) - 7.199999999999999) / 0.05)) - 2.1e-4 * ln(1 + exp((1.5 - V(n7)) / 0.05))
C3 n7 0 3e-11
E4 n6 0 n7 0 1
R5 n5 n8 3.3e3
C6 n8 0 4.7e-8
C7 n5 n6 1e-10
R8 n5 n9 4.7e3
R9 n9 n6 9.090909090909091e4
R10 n6 n10 9.090909090909094e3
C11 n9 n10 1e-9
C12 n10 n11 6.8e-8
R13 n11 n12 4.7e3
B14in 0 n14 I = 2.1e-4 * tanh(V(n3,n12)/7.427230677621782e-2)
B14rail n14 0 I = 2.827433388230814e-8 * (V(n14) - 4.35) + 2.1e-4 * ln(1 + exp((V(n14) - 7.199999999999999) / 0.05)) - 2.1e-4 * ln(1 + exp((1.5 - V(n14)) / 0.05))
C15 n14 0 3e-11
E16 n13 0 n14 0 1
R17 n13 n12 6.8e5
C18 n13 n12 6.8e-11
C19 n13 n15 1e-7
R20 n15 n16 4.7e3
D21_0_0 n16 n31 D210J
D21_0_1 n31 0 D210X
D21_1_0 0 n32 D211J
D21_1_1 n32 n16 D211X
R22 n16 n17 3e3
C23 n17 n18 4.7e-8
R24 n18 0 9.090909090909092e3
C25 n17 n19 2.2e-7
R26 n19 n20 4.7e4
B27in 0 n22 I = 2.1e-4 * tanh(V(n3,n20)/7.427230677621782e-2)
B27rail n22 0 I = 2.827433388230814e-8 * (V(n22) - 4.35) + 2.1e-4 * ln(1 + exp((V(n22) - 7.199999999999999) / 0.05)) - 2.1e-4 * ln(1 + exp((1.5 - V(n22)) / 0.05))
C28 n22 0 3e-11
E29 n21 0 n22 0 1
R30 n21 n20 2.2e5
C31 n21 n20 4.7e-10
R32 n21 n23 1e4
C33 n23 0 4.7e-9
C34 n23 n24 3.3e-8
R35 n24 0 4.545454545454546e3
R36 n23 n25 1e4
C37 n21 n25 6.8e-9
C38 n25 0 4.7e-9
C39 n25 n26 4.7e-7
R40 n26 n27 1e5
E41 n28 0 n3 n27 1e9
R42 n28 n27 1e5
C43 n28 n27 2.2e-10
R44 n28 n29 1e3
C45 n29 n30 4.7e-6
R46 n30 0 1e4
R47 n30 0 1e6
.model D210J D(IS=2e-7 N=1.3 EG=0.67 XTI=3 TNOM=25)
.model D210X D(IS=1.4e-8 N=1.98 EG=1.11 XTI=3 TNOM=25)
.model D211J D(IS=1.4e-8 N=1.98 EG=1.11 XTI=3 TNOM=25)
.model D211X D(IS=2.52e-9 N=1.752 EG=1.11 XTI=3 TNOM=25)
.op
.print op V(n30)
.end
