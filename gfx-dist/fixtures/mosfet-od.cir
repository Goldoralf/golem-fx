* MOSFET OD
* generated by gfx-dsp circuit_nl::Netlist::to_spice
.temp 25
VIN0 n1 0 DC 0
VIN1 n2 0 DC 9
VIN2 n3 0 DC 4.5
C0 n1 n4 2.2e-8
R1 n4 n5 1e4
R2 n5 n3 4.7e5
B3in 0 n8 I = 3.9e-4 * tanh(V(n5,n6)/6.896714200648798e-1)
B3rail n8 0 I = 2.8274333882308137e-9 * (V(n8) - 4.5) + 3.9e-4 * ln(1 + exp((V(n8) - 7.5) / 0.05)) - 3.9e-4 * ln(1 + exp((1.5 - V(n8)) / 0.05))
C4 n8 0 3e-11
E5 n7 0 n8 0 1
R6 n7 n9 1.8e4
R7 n9 n6 9.090909090909091e4
C8 n7 n6 2.2e-10
R9 n6 n10 2.2e3
C10 n10 0 1e-7
R11 n7 n11 1e4
D12_0_0 n11 n3 D120J
B12_0ch n11 n3 I = 1e-1 * (V(n11,n3) > 2.1 ? (V(n11,n3) - 2.1)^2 : 0)
D12_1_0 n3 n11 D121J
B12_1ch n3 n11 I = 1e-1 * (V(n3,n11) > 2.1 ? (V(n3,n11) - 2.1)^2 : 0)
C13 n11 n3 1e-9
R14 n11 n12 1e4
B15in 0 n15 I = 3.9e-4 * tanh(V(n12,n13)/6.896714200648798e-1)
B15rail n15 0 I = 2.8274333882308137e-9 * (V(n15) - 4.5) + 3.9e-4 * ln(1 + exp((V(n15) - 7.5) / 0.05)) - 3.9e-4 * ln(1 + exp((1.5 - V(n15)) / 0.05))
C16 n15 0 3e-11
E17 n14 0 n15 0 1
R18 n14 n13 1.5e5
C19 n14 n13 2.2e-10
R20 n13 n16 3.9e4
C21 n16 0 1e-7
C22 n14 n17 1e-6
R23 n17 n18 3.3e4
R24 n17 n18 1e9
C25 n18 n19 4.7e-8
R26 n19 0 5e3
R27 n18 0 5e5
R28 n18 0 1e6
.model D120J D(IS=1e-12 N=1.1 EG=1.11 XTI=3 TNOM=25)
.model D121J D(IS=1e-12 N=1.1 EG=1.11 XTI=3 TNOM=25)
.op
.print op V(n18)
.end
