* Op-Amp Dist
* generated by gfx-dsp circuit_nl::Netlist::to_spice
.temp 25
VIN0 n1 0 DC 0
VIN1 n2 0 DC 9
VIN2 n3 0 DC 4.5
C0 n1 n4 2.2e-8
R1 n4 n3 1e6
R2 n4 n5 1e3
C3 n5 0 1e-9
B4in 0 n10 I = 9e-6 * tanh(V(n5,n6)/4.7746482927568605e-2)
B4rail n10 0 I = 6.283185307179586e-10 * (V(n10) - 4.5) + 9e-6 * ln(1 + exp((V(n10) - 8) / 0.05)) - 9e-6 * ln(1 + exp((1 - V(n10)) / 0.05))
C5 n10 0 3e-11
E6 n7 0 n10 0 1
R7 n7 n6 9.090909090909092e3
C8 n7 n6 1e-10
R9 n6 n8 5.6e2
C10 n8 0 4.7e-6
R11 n6 n9 4.7e1
C12 n9 0 2.2e-6
C13 n7 n11 4.7e-6
R14 n11 n12 1e3
D15_0_0 n12 0 D150J
D15_1_0 0 n12 D151J
R16 n12 n13 9.090909090909092e3
R17 n13 n14 1.5e3
C18 n14 0 3.3e-9
C19 n14 n15 2.2e-8
R20 n15 n3 1e6
E21 n16 0 n15 0 1
C22 n16 n17 1e-6
R23 n17 0 1e5
.model D150J D(IS=2.52e-9 N=1.752 EG=1.11 XTI=3 TNOM=25)
.model D151J D(IS=2.52e-9 N=1.752 EG=1.11 XTI=3 TNOM=25)
.op
.print op V(n17)
.end
