* Booster Dist
* generated by gfx-dsp circuit_nl::Netlist::to_spice
.temp 25
VIN0 n1 0 DC 0
VIN1 n2 0 DC 9
VIN2 n3 0 DC 4.5
R0 n1 n4 1e3
C1 n4 n5 4.7e-8
R2 n5 n3 4.7e5
E3 n6 0 n5 0 1
C4 n6 n7 4.7e-8
R5 n7 0 1e5
R6 n8 n7 4.7e5
C7 n8 n7 2.5e-10
R8 n2 n8 1e4
R9 n9 0 2.2e1
Q10 n8 n7 n9 Q10M
C11 n8 n10 4.7e-7
R12 n10 n3 1e5
B13in 0 n13 I = 1.2e-5 * tanh(V(n10,n11)/7.957747154594767e-2)
B13rail n13 0 I = 1.5079644737231007e-9 * (V(n13) - 3.775) + 1.2e-5 * ln(1 + exp((V(n13) - 7.5) / 0.05)) - 1.2e-5 * ln(1 + exp((0.05 - V(n13)) / 0.05))
C14 n13 0 3e-11
E15 n12 0 n13 0 1
R16 n12 n11 5e4
R17 n11 n14 5e4
C18 n12 n11 2.5e-10
R19 n14 n15 4.7e3
C20 n15 0 1e-6
C21 n12 n16 4.7e-7
R22 n16 n17 2.2e3
D23_0_0 n17 0 D230J
D23_1_0 0 n17 D231J
C24 n17 0 1e-8
R25 n17 n18 6.8e3
C26 n18 0 1e-7
C27 n17 n19 2.2e-8
R28 n19 0 6.8e3
R29 n19 n20 2.2e3
R30 n18 n21 1e4
R31 n21 n20 1e4
R32 n21 0 1e5
E33 n22 0 n21 0 1
C34 n22 n23 1e-6
R35 n23 0 1e6
.model Q10M NPN(IS=2e-14 BF=400 BR=4 EG=1.11 XTI=3 TNOM=25)
.model D230J D(IS=2.52e-9 N=1.752 EG=1.11 XTI=3 TNOM=25)
.model D231J D(IS=2.52e-9 N=1.752 EG=1.11 XTI=3 TNOM=25)
.op
.print op V(n23)
.end
