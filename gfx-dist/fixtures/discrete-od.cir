* Discrete OD
* generated by gfx-dsp circuit_nl::Netlist::to_spice
.temp 25
VIN0 n1 0 DC 0
VIN1 n2 0 DC 8.1
VIN2 n3 0 DC 4.05
R0 n1 n4 1e4
C1 n4 n5 4.7e-8
R2 n5 n3 1e6
E3 n6 0 n5 0 1
C4 n6 n7 1e-7
R5 n7 n3 2.2e5
J6 n10 n7 n11 J6M
J7 n2 n8 n11 J7M
R8 n11 0 4.7e3
R9 n2 n10 2.2e3
Q10 n9 n10 n2 Q10M
C11 n10 n9 4.7e-11
R12 n9 0 2.2e3
R13 n9 n12 2.2727272727272728e4
R14 n12 n8 2.2e4
C15 n8 n9 4.7e-11
C16 n8 n13 1.5e-7
R17 n13 0 1.5e3
R18 n9 n14 1e5
C19 n9 n17 2.2e-10
R20 n17 n15 3.3e5
C21 n14 n15 1e-7
C22 n14 n16 4.7e-8
R23 n16 0 1.5e4
R24 n15 n16 1e6
D25_0_0 n15 n42 D250J
D25_0_1 n42 0 D250J
D25_1_0 0 n43 D251J
D25_1_1 n43 n15 D251J
C26 n15 n18 2.2e-9
R27 n18 n3 1e6
J28 n21 n18 n22 J28M
J29 n2 n19 n22 J29M
R30 n22 0 4.7e3
R31 n2 n21 2.2e3
Q32 n20 n21 n2 Q32M
C33 n21 n20 1e-10
R34 n20 0 2.2e3
R35 n20 n23 2.2727272727272728e4
R36 n23 n19 3.3e4
C37 n19 n20 1e-10
R38 n19 n24 2.2e3
C39 n24 0 1e-6
R40 n20 n25 5.6e3
C41 n20 n25 6.8e-9
C42 n25 0 5.6e-9
C43 n25 n26 1.8e-8
C44 n25 n27 8.3e-8
R45 n27 n26 2.2e7
R46 n28 n29 5e3
R47 n29 n26 5e3
C48 n28 0 1.8e-8
R49 n29 n30 9.090909090909091e4
R50 n30 0 9.090909090909092e3
C51 n30 n31 4.7e-8
R52 n31 n3 4.7e5
E53 n33 0 n31 n32 1e9
C54 n33 n32 2.2e-9
R55 n33 n32 6.8e3
C56 n32 n34 5.6e-8
C57 n34 n35 5.6e-8
R58 n35 n3 4.7e5
E59 n37 0 n35 0 1
R60 n37 n36 8.28792874873737e1
R61 n35 n36 3.315171499494948e4
R62 n36 0 1e4
R63 n34 n36 1.2e3
C64 n33 n38 1e-6
R65 n38 n3 1e5
E66 n39 0 n38 0 1
C67 n39 n40 1e-6
R68 n40 0 1e5
R69 n40 n41 1e3
R70 n41 0 1e6
.model J6M NJF(VTO=-0.45 BETA=1.8e-2 LAMBDA=0.004 IS=1e-14 N=1 VTOTC=0 BETATCE=0 TNOM=25)
.model J7M NJF(VTO=-0.45 BETA=1.8e-2 LAMBDA=0.004 IS=1e-14 N=1 VTOTC=0 BETATCE=0 TNOM=25)
.model Q10M PNP(IS=2e-14 BF=300 BR=4 EG=1.11 XTI=3 TNOM=25)
.model D250J D(IS=2.52e-9 N=1.752 EG=1.11 XTI=3 TNOM=25)
.model D250J D(IS=2.52e-9 N=1.752 EG=1.11 XTI=3 TNOM=25)
.model D251J D(IS=2.52e-9 N=1.752 EG=1.11 XTI=3 TNOM=25)
.model D251J D(IS=2.52e-9 N=1.752 EG=1.11 XTI=3 TNOM=25)
.model J28M NJF(VTO=-0.45 BETA=1.8e-2 LAMBDA=0.004 IS=1e-14 N=1 VTOTC=0 BETATCE=0 TNOM=25)
.model J29M NJF(VTO=-0.45 BETA=1.8e-2 LAMBDA=0.004 IS=1e-14 N=1 VTOTC=0 BETATCE=0 TNOM=25)
.model Q32M PNP(IS=2e-14 BF=300 BR=4 EG=1.11 XTI=3 TNOM=25)
.op
.print op V(n41)
.end
